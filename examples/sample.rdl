property user_prop1 { type = string; component = field|reg;};
addrmap am1 {
  enum e1 {
    a1 = 32'd0; b1 = 32'd2;
  };
  default encode = enum {
                      a = 1'b0;
                      b = 1'b1 {
                        name="off";
                      }; 
                   };
  default sw = r;
  default woclr;
  signal {} generic_reset;
  default resetsignal = generic_reset;
  name = "addrmap";
  regfile rf {
    reg {
      name = "data";
      desc = "Data read/write register";
      field {
        level intr;
        name = "data_field";
        desc = "Data read/write field";
        rclr;
        sw = rw;
        hw = r;
        user_prop1;
        reset = 32'd0;
      } data_field[31:0];
      field {
        encode = e1;
        name = "df2";
        fieldwidth = 2;
      } df2[2];
    } data[1] @0x0 +=0x2;
  };
  rf rf1;
  rf rf2;
  rf1.data->accesswidth = 32;
  rf1.data->user_prop1 = "hello";
  rf1.data[0].df2->name="data2";
  rf1.data[0].data_field->reset=32'd1;
};
