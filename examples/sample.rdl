addrmap am1 {
  name = "addrmap";
  reg {
    name = "data";
    desc = "Data read/write register";
    field {
      name = "data_field";
      desc = "Data read/write field";
      sw = rw;
      hw = r;
      reset = 32'd2;
    } data_field[31:0];
  } data @0x0;
};
