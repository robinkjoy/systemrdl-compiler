property user_prop1 { type = string; component = field|reg; default = "hi";};
addrmap am1 {
  default encode = enum {
                      a = 1'b0;
                      b = 1'b1 {
                        name="off";
                      }; 
                   };
  default sw = r;
  signal {} generic_reset;
  default resetsignal = generic_reset;
  name = "addrmap";
  regfile {
    reg {
      name = "data";
      desc = "Data read/write register";
      field {
        name = "data_field";
        desc = "Data read/write field";
        rclr;
        //sw = rw;
        hw = r;
      } data_field[31:0];
    } data @0x0 +=0x2;
  } rf1;
};
