addrmap am1 {
  name = "addrmap";
  regfile {
    reg {
      name = "data";
      desc = "Data read/write register";
      field {
        name = "data_field";
        desc = "Data read/write field";
        sw = rw;
        hw = r;
        reset = 32'd2;
      } data_field[31:0] = 32'd12;
    } data @0x0 +=0x2;
  } rf1;
};
