property user_prop1 { type = string; component = field|reg; default = "hi";};
addrmap am1 {
  default encode = enum {on = 1'b1; off = 1'b0 { name = "Off";};};
  name = "addrmap";
  regfile {
    reg {
      name = "data";
      desc = "Data read/write register";
      field {
        name = "data_field";
        desc = "Data read/write field";
        rclr;
        sw = rw;
        hw = r;
        reset = 32'd2;
      } data_field[31:0] = 32'd12;
    } data @0x0 +=0x2;
  } rf1;
};
